* SPICE3 file created from full_adder_1bit.ext - technology: sky130A

.option scale=10m

X0 a_106100_100000# a_105900_99000# a_104500_100000# w_104000_99000# sky130_fd_pr__pfet_01v8 ad=1.04u pd=7.2m as=1.04u ps=7.2m w=1000 l=200
X1 a_101100_100000# a_100900_99000# a_100000_100000# SUB sky130_fd_pr__nfet_01v8 ad=0.9u pd=3.8m as=0.9u ps=3.8m w=1000 l=200
C0 w_104000_99000# a_105900_99000# 6.47954f
C1 a_104700_100200# w_104000_99000# 4.68973f
C2 m1_106500_100200# a_106700_100200# 4.47046f
C3 a_106700_100200# w_104000_99000# 4.68973f
C4 a_104700_100200# m1_104500_100200# 4.47046f
C5 a_100900_99000# SUB 6.67708f **FLOATING
C6 w_104000_99000# SUB 0.192p **FLOATING
